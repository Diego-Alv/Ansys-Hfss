# Ansys Electronics Desktop project, version 2024.2
materials:
  vacuum: permittivity=1

design HFSSDesign1 (HFSS, HFSS Modal Network, model units mm)
variables:
  lambda = 22.86mm
geometry:
  Box1 [vacuum] = box(corner=(0mm, 0mm, 0mm), size=(-30mm, 22.86mm, 10.16mm))
  coordinate_system RelativeCS1 = origin=(0mm, 11.43mm, 5.08mm) x=(1mm, 0mm, 0mm) y=(0mm, 1mm, 0mm)
boundaries and excitations:
  PerfE1: Perfect E Faces=Box1.face(+z, -y, -z, +y)
  1: Wave Port Faces=Box1.face(+x) WavePortType=Modal NumModes=5 Modes{Mode1{CharImp=Zpi} Mode2{CharImp=Zpi} Mode3{CharImp=Zpi} Mode4{CharImp=Zpi} Mode5{CharImp=Zpi}}
  2: Wave Port Faces=Box1.face(-x) WavePortType=Modal NumModes=5 Modes{Mode1{CharImp=Zpi} Mode2{CharImp=Zpi} Mode3{CharImp=Zpi} Mode4{CharImp=Zpi} Mode5{CharImp=Zpi}}
setups:
  Setup1: HfssDriven Frequency=8GHz MaxDeltaS=0.02 MaximumPasses=6 MinimumPasses=1 MinimumConvergedPasses=1 PercentRefinement=30 BasisOrder=1 PortAccuracy=2 DrivenSolverType="Direct Solver"
    sweep Sweep: 5GHz to 15GHz step 0.1GHz; Type=Interpolating InterpTolerance=0.5 InterpMaxSolns=250 InterpUsePortImped=false PassivityErrorTolerance=0.0001
source amplitudes:
  1:1: 1W 0deg
  1:2..1:5, 2:1..2:5: 0W 0deg
field plots:
  Mag_E1, Mag_E2: E Field over a plane on Setup1 : LastAdaptive at Freq=8GHz Phase=0deg
  Mag_E3: E Field over Box1.face(+x) on Setup1 : LastAdaptive at Freq=8GHz Phase=0deg
reports:
  Gamma Plot 1: im(Gamma(1:1)), im(Gamma(1:2)), im(Gamma(1:3)), im(Gamma(1:4)), im(Gamma(1:5)) vs Freq on Setup1 : Sweep
  Gamma Plot 2:
